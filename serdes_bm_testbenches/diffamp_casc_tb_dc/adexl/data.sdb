ADE simulation setup
Run mode: Single Run, Sweeps and Corners
Tests:
  ac_dc: serdes_bm_testbenches/diffamp_casc_tb_dc/schematic, simulator spectre
Global variables:
  cload = 4.714f
  cw = 6f
  rw = 200
  vbias = 0.4052
  vdd = 0.9
  vindc = 0.775
  vload = 0.3843
  vin_step = 1e-3
  vindc_diff = 0
  vin_max = 0.3
  tsim = 1n
  tstep = 0.5e-12
  td = 100p
  tr = 0.1p
