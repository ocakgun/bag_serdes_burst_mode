ADE simulation setup
Run mode: Single Run, Sweeps and Corners
Tests:
  ac_dc: AAAFOO_diffamp2/dynlatch_casc_tb_ac/config, simulator spectre
Global variables:
  cload = 4.714f
  cw = 6f
  rw = 200
  vbias = 0.4052
  vdd = 0.9
  vindc = 0.775
  vload = 0.3843
  vin_step = 1e-3
  vindc_diff = 0
  vstar = 0.3
Corners (nominal off):
  model folders: /tools/tstech16/CLN16FFC/PDK/models
  tt: temperature=25; vbias=0.3552; vload=0.3; toplevel.scs[top_tt]
  ff (off): temperature=25; vbias=0.4052; toplevel.scs[top_ff]
  ss (off): temperature=25; vbias=0.4052; vload=0.27; toplevel.scs[top_ss]
  sf (off): temperature=25; vbias=0.4052; toplevel.scs[top_sf]
  fs (off): temperature=25; vbias=0.4052; toplevel.scs[top_fs]
  ff_hot (off): temperature=65; vbias=0.4052; toplevel.scs[top_ff]
  ss_hot (off): temperature=65; vbias=0.4052; toplevel.scs[top_ss]
  ss_cold: temperature=0; vbias=0.4052; toplevel.scs[top_ss]
