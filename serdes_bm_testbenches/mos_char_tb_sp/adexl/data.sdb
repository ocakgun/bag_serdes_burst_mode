ADE simulation setup
Run mode: Single Run, Sweeps and Corners
Tests:
  serdes_bm_testbenches:mos_char_tb_sp:1: serdes_bm_testbenches/mos_char_tb_sp/schematic, simulator spectre
Global variables:
  cblk = 1u
  lblk = 1u
  rp = 50
  vb_dc = 0.0
  char_freq = 1e3
  vgs_start = 0.0
  vgs_stop = 1.0
  vgs_num = 10
  vbs = 0
  vds = 0.5
  vgs = 0.5
