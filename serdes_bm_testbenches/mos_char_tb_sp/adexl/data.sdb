ADE simulation setup
Run mode: Single Run, Sweeps and Corners
Tests:
  tb_sp: serdes_bm_testbenches/mos_char_tb_sp/schematic, simulator spectre
Global variables:
  cblk = 1u
  lblk = 1u
  rp = 50
  vb_dc = 0.0
  vbs_dc = 0.0
  vds_dc = 0.5
  vgs_dc = 0.5
  char_freq = 1e3
  vgs_start = 0.0
  vgs_stop = 1.0
  vgs_num = 10
