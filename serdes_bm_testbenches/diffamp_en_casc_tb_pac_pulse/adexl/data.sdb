ADE simulation setup
Run mode: Single Run, Sweeps and Corners
Tests:
  pac: serdes_bm_testbenches/diffamp_en_casc_tb_pac_pulse/schematic, simulator spectre
Global variables:
  bias_in = 0.8
  bias_load = 400m
  bias_tail = 0.36
  cl = 5f
  clk_freq = 10e9
  clk_phase = 0
  clk_vpp = 0.8
  vdd = 1.0
  k = 4
  m_out = 50
  n_in = 60
  in_freq_max = 150e9
  bias_casc = 0.7
  tstab = 200p
