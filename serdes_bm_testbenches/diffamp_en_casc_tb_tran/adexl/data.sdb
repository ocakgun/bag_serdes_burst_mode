ADE simulation setup
Run mode: Single Run, Sweeps and Corners
Tests:
  tb_tran: serdes_bm_testbenches/diffamp_en_casc_tb_tran/schematic, simulator spectre
Global variables:
  cload = 10f
  vcasc = 1
  vdd = 1
  vin_amp = 0.1
  vin_freq = 5e9
  vindc = 0.8
  vload = 0.5
  vtail = 0.5
  tsim = 1n
  tstep = 1n
