ADE simulation setup
Run mode: Single Run, Sweeps and Corners
Tests:
  serdes_bm_testbenches:diffamp_casc_tb_bias:1: serdes_bm_testbenches/diffamp_casc_tb_bias/schematic, simulator spectre
Global variables:
  amp_gain = 200
  vcasc = 0.9
  vdd = 0.9
  vindc = 0.78
  voutdc = 0.78
  vtail = 0.5
