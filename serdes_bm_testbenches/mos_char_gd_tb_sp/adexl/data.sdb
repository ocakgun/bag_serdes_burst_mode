ADE simulation setup
Run mode: Single Run, Sweeps and Corners
Tests:
  sp_dc: serdes_bm_testbenches/mos_char_gd_tb_sp/schematic, simulator spectre
Global variables:
  cblk = 1u
  lblk = 1u
  rp = 50
  char_freq = 1e3
  vgs_start = 0.0
  vgs_stop = 1.0
  vgs_num = 10
  vbs = 0
  vds = 0.5
  vgs = 0.5
  vs_dc = 0
